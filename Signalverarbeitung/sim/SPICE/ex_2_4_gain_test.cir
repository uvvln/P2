* Use the SPICE model for the op amp
.include LM358.lib

* Define a voltage source which
* provides the sine input signal for the attenuator
Vsource Vsource 0 SIN(0 1 1k 0 0 0 100)

* OPV Supply Voltage
V12 V12 0 DC 12
Vn12 Vn12 0 DC -12

* First configuration: Use  1 + (R1 / R2)
* The amplification factor should be 3
R1 VopOut Vatt 2.26k
* Use the following values for R2
* 2260, 904, 565, 347, 282
* R2 Vatt 0 2260
* R2 Vatt 0 904
* R2 Vatt 0 565
* R2 Vatt 0 347
R2 Vatt 0 282
* OPV instantiations
* connections:      non-inverting input
*                   |   inverting input
*                   |   |   positive power supply
*                   |   |   |   negative power supply
*                   |   |   |   |   output
*                   |   |   |   |    |
*                   |   |   |   |    |
XOP1 					Vsource Vatt V12 Vn12 VopOut LM358

* Now define the simulation parameters
* We want to perform a transient analysis, which
* simulates the time behaviour of the circuit
* The duration of the simulation is set to 5µs
* and the time steps are set to 0.1 nano seconds
* a finer step size increases the resolution but also
* needs more time to calculate the transient analysis.
.tran 1u 2m

* Here we define what we want ngspice to perform and report in the end
.control
* run the simulation
run

* plot the voltage on some interesting virtual wires
plot v(Vsource) v(VopOut) title "input and output voltage"
.endc
.end
