* Use the SPICE model for the op amp
.include LM358.lib

* Define a voltage source which
* provides the sine input signal for the attenuator
Vsource Vsource 0 SIN(0 9 100k 0 0 0 100)

* now add a resistor which is connected to Vsource on one end
* and to the virtual wire Vout at the other end
R1 Vsource Vout 11500
* Add the second resistor which continues the path to ground (= 0)
R2 Vout Voff 2260
* Now add the capacitors
C1 Vsource Vout 82p
* trimmer parallel to C1, set to 15 pF
Ctrim Vsource Vout 15p
* C2
C2 Vout Voff 470p
* Oscilloscope internal capacitor
Cosc Vsource Voff 15p
* oscilloscope internal resistor
Rosc Vsource Voff 1000k

* Generate the offset voltage
* This is the desired reference voltage
* Voff Voff 0 DC 1.79478V
* generate from +12V reference voltage
V12 V12 0 DC 12
Vn12 Vn12 0 DC -12
* attenuator
Rref1 V12 Voffout 16.2k
Rref2 Voffout 0 2.87k
* instantiate the op amp as voltage follower
* connections:      non-inverting input
*                   |   inverting input
*                   |   |   positive power supply
*                   |   |   |   negative power supply
*                   |   |   |   |   output
*                   |   |   |   |   |
*                   |   |   |   |   |
XOP1 					Voffout Voff V12 Vn12 Voff LM358

* Now define the simulation parameters
* We want to perform a transient analysis, which
* simulates the time behaviour of the circuit
* The duration of the simulation is set to 5µs
* and the time steps are set to 0.1 nano seconds
* a finer step size increases the resolution but also
* needs more time to calculate the transient analysis.
.tran 0.1n 20u

* Here we define what we want ngspice to perform and report in the end
.control
* run the simulation
run

* plot the voltage on some interesting virtual wires
plot v(Vsource) v(Voff) v(Vout) title "input and output voltage"
.endc
.end
