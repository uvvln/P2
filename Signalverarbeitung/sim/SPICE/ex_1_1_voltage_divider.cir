* A resistive voltage divider which
* also adds an offset

* Define a voltage source which
* provides the sine input signal for the attenuator
Vsource Vsource 0 SIN(0 9V 100k 0 0 0 100)

* now add a resistor which is connected to Vsource on one end
* and to the virtual wire Vout at the other end
R1 Vsource Vout 11500
* Add the second resistor which continues the path to ground (= 0)
R2 Vout 0 2260

* Now define the simulation parameters
* We want to perform a transient analysis, which
* simulates the time behaviour of the circuit
* The duration of the simulation is set to 5µs
* and the time steps are set to 0.1 nano seconds
* a finer step size increases the resolution but also
* needs more time to calculate the transient analysis.
.tran 0.1n 20u

* Here we define what we want ngspice to perform and report in the end
.control
* run the simulation
run

* plot the voltage on some interesting virtual wires
plot v(Vsource) v(Vout) title "input and output voltage"
.endc
.end
