* Use the SPICE model for the op amp
.include LM358.lib

* Define a voltage source which
* provides the sine input signal for the attenuator
Vsource Vsource 0 SIN(0 1 1k 0 0 0 100)

* OPV Supply Voltage
V12 V12 0 DC 12
Vn12 Vn12 0 DC -12

* First configuration: Use  1 + (R1 / R2)
* The amplification factor should be 3
Ra1 VopAout VattA 22.6k
Ra2 VattA 0 11.5k
* OPV instantiations
* connections:      non-inverting input
*                   |   inverting input
*                   |   |   positive power supply
*                   |   |   |   negative power supply
*                   |   |   |   |   output
*                   |   |   |   |    |
*                   |   |   |   |    |
XOP1 					Vsource VattA V12 Vn12 VopAout LM358

* Second configuration: Use 1 + (R2 / R1)
* The amplification factor should be 1.5
Rb1 VopBout VattB 11.5k
Rb2 VattB 0 22.6k
* OPV instantiations
* connections:      non-inverting input
*                   |   inverting input
*                   |   |   positive power supply
*                   |   |   |   negative power supply
*                   |   |   |   |   output
*                   |   |   |   |    |
*                   |   |   |   |    |
XOP2 					Vsource VattB V12 Vn12 VopBout LM358

* Now define the simulation parameters
* We want to perform a transient analysis, which
* simulates the time behaviour of the circuit
* The duration of the simulation is set to 5µs
* and the time steps are set to 0.1 nano seconds
* a finer step size increases the resolution but also
* needs more time to calculate the transient analysis.
.tran 1u 2m

* Here we define what we want ngspice to perform and report in the end
.control
* run the simulation
run

* plot the voltage on some interesting virtual wires
plot v(Vsource) v(VopAout) v(VopBout) title "input and output voltage"
.endc
.end
