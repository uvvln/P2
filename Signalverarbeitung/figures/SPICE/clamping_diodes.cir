* Define a voltage source which
* provides the sine input signal for the attenuator
Vsource Vsource 0 SIN(0 9 1k 0 0 0 100)

* Clamping Voltages
V5 V5 0 DC 5
Vn5 Vn5 0 DC -5

* Define the model for the 1N4148 Diode
.model 1N4148 D(Is=2.52e-9 Rs=0.568 N=1.906 Cjo=1e-11 M=0.333 Vj=0.75 Eg=1.11 Bv=100 Ibv=0.1u Tt=4e-9)

* Add a resistor to limit the current for the clamping diodes
Rlimit Vsource Vclamp 10k

* Add the clamping Diodes
D1 Vn5 Vclamp 1N4148
D2 Vclamp V5 1N4148

* Now define the simulation parameters
* We want to perform a transient analysis, which
* simulates the time behaviour of the circuit
* The duration of the simulation is set to 5µs
* and the time steps are set to 0.1 nano seconds
* a finer step size increases the resolution but also
* needs more time to calculate the transient analysis.
.tran 1u 2m

* Here we define what we want ngspice to perform and report in the end
.control
* run the simulation
run

* plot the voltage on some interesting virtual wires
plot v(Vsource) v(Vclamp) title "input and output voltage"
.endc
.end
