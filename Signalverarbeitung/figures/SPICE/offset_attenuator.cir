* A resistive voltage divider which
* also adds an offset

* Define a voltage source which
* provides the sine input signal for the attenuator
Vsource Vsource 0 SIN(0 9V 500k 0 0 0 100)
* Vsource Vsource 0 PULSE(-12 12 0.5u 0 0 0.5u 1u 5)

* now add a resistor which is connected to Vsource on one end
* and to the virtual wire Vout at the other end
R1 Vsource Vout 11.5k
* Add the second resistor which continues the path to ground (= 0)
R2 Vout Voff 2.26k
* Now add the capacitors
C1 Vsource Vout 94p
C2 Vout Voff 470p

Voff Voff 0 DC 1.8V

* Now define the simulation parameters
* We want to perform a transient analysis, which
* simulates the time behaviour of the circuit
* The duration of the simulation is set to 5µs
* and the time steps are set to 0.1 nano seconds
* a finer step size increases the resolution but also
* needs more time to calculate the transient analysis.
.tran 0.1n 5u

* Here we define what we want ngspice to perform and report in the end
.control
* run the simulation
run

* plot the voltage on some interesting virtual wires
plot v(Vsource) v(Vout) title "input and output voltage"
.endc
.end
